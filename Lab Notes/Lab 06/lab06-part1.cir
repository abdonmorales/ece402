* /Users/abdonmorales/Library/CloudStorage/OneDrive-TheUniversityofTexasatAustin/Summer 2026/ECE 402/Lab Notes/Lab 06/lab06-part1.asc
* Generated by LTspice 26.0.2 for MacOS.
V1 Vin 0 SINE(0 5 100)
R1 N001 Vin 10K
R2 0 Vout 10K
C1 N001 0 5.3n
C2 Vout N001 53n
.tran 10m
.backanno
.end
