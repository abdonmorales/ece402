* /Users/abdonmorales/Library/CloudStorage/OneDrive-TheUniversityofTexasatAustin/Summer 2026/ECE 402/Lab Notes/Lab 06/lab06-part2.asc
* Generated by LTspice 26.0.2 for MacOS.
V1 Vin 0 SINE(0 5 100)
R1 N002 Vin 10K
R2 0 N003 10K
C1 N002 0 5.3n
C2 N003 N001 53n
X§U1 N001 N002 N001 opamp Aol=100K GBW=10Meg ;§pnba invin)noninvin)out
X§U2 Vout N003 Vout opamp Aol=100K GBW=10Meg ;§pnba invin)noninvin)out
.tran 10m
.inc opamp.sub
.backanno
.end
