* G:\My Drive\lab07.asc
* Generated by LTspice 26.0.2 for Windows.
R1 Vout N003 7.5k
R Vout N001 10k
X§U1 N003 N001 N002 N004 Vout level2 Avol=1Meg GBW=10Meg Slew=10Meg Ilimit=25m Rail=0 Vos=0 En=0 Enk=0 In=0 Ink=0 Rin=500Meg ;§pnba In+)In-)V+)V-)OUT
C1 N001 0 100µF
R2 N003 0 2.4k
V1 N002 0 5
V2 0 N004 5
.tran 1
.ic V(vout)=1
* Library below included based on ModelFile attribute of instance X§U1 (C:\Users\Abdon Morales\AppData\Local\LTspice\lib\sym\OpAmps\UniversalOpAmp2.asy)
.lib UniversalOpAmp2.lib
.backanno
.end
