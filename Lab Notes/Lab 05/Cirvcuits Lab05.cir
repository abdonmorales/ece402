* C:\Users\Abdon Morales\OneDrive - The University of Texas at Austin\Summer 2026\ECE 402\Lab Notes\Lab 05\Cirvcuits Lab05.asc
* Generated by LTspice 26.0.2 for Windows.
R1 N003 0 100K
R2 N004 N003 47K
R3 N005 N004 47K
R4 N001 N005 47K
R5 N002 N001 47K
R6 N008 N005 100K
R7 N007 N004 100K
R8 N006 N003 100K
X§U1 N001 0 N002 opamp Aol=100K GBW=10Meg ;§pnba invin)noninvin)out
R9 N001 N009 100K
V1 N006 0 0
V2 N007 0 0
V3 N008 0 0
V4 N009 0 5
.include opamp.sub
.op
.backanno
.end
