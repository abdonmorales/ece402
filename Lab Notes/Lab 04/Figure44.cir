* /Users/abdonmorales/Library/CloudStorage/OneDrive-TheUniversityofTexasatAustin/Summer 2026/ECE 402/Lab Notes/Lab 04/Figure44.asc
* Generated by LTspice 26.0.2 for MacOS.
V1 N001 N004 3
R1 N002 N001 1000
R2 N002 N004 4700
R3 N003 N002 1000
R4 N003 N004 4700
R5 N005 N003 1000
RL N005 N004 2200
.op
.backanno
.end
